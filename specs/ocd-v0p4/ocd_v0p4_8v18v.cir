* ocd_v0p4_8v18v: OCD-style overdrive v0.4: S002-verified topology + user node connections; 8-18V DC center-negative, 9V nominal. D_FB_FIX moves C4/C8 in series with R5/R11 (the prior parallel placement saturated both op-amps). Adds 1N5819 protection, status LED, 9V battery/DC-jack provision, and an explicit HP/LP SW1. Not a verified Fulltone netlist; 2N7000/1N34A/1N5819 models are approximations.
* Generated by circuit-design-skill.
* Models: declared models (no vendor provenance).

* --- device models ---
.model APPROX_1N5819 D(Is=1e-6 N=1.05 Rs=0.05)
* model provenance: vendor=Texas Instruments; part=TL082 (macromodel); file=../models/TL082.301; source=TI SLOJ070 / S007
* TL082: None
* model provenance: part=2N7000 APPROX sim-only; file=../models/APPROX_2N7000.lib; source=local APPROX; not manufacturer model
* APPROX_2N7000: None
* model provenance: part=1N34A Ge APPROX sim-only (S002-confirmed D1 type); file=../models/APPROX_1N34A.lib; source=local APPROX; not manufacturer model; D1 per S002 C027
* APPROX_1N34A: None
.model SW1MODEL SW(Ron=0.05 Roff=1e6 Vt=2.5 Vh=0.1)
.model LED_RED D(Is=4.3e-19 N=1.8 Rs=5)

* --- circuit ---
V1 VCC_JACK 0 DC 9
V_IN IN IN_SRC SIN(0 50m 1k)
V_AC IN_SRC 0 DC 0 AC 1
D_PWR VCC_JACK VCC APPROX_1N5819
R1 VCC VCC_F 100
C2 VCC_F 0 10u
C3 VCC_F 0 100n
R4 VCC_F VREF 10k
R7 VREF 0 10k
C5 VREF 0 10u
C1 IN IN_B 22n
R2 IN_B 0 1Meg
R6 IN_B VREF 470k
R3 IN_B X1_P 10k
X1A X1_P X1_FB VCC_F 0 X1_OUT TL082
R5 X1_FB X1_RG 2.2k
R8 X1_FB X2_W 18k
R_X2POT X2_W X1_OUT 500k
C4 X1_RG VREF 100n
C6 X1_OUT X1_FB 220p
R9 X1_OUT CLIP_A 10k
C7 VREF CLIP_A 10n
R10 CLIP_A CLIP_B 10k
R12 VREF CLIP_B 220k
M1 VREF VREF CLIP_A CLIP_A APPROX_2N7000
M2 VREF M2_D1_NODE M2_D1_NODE M2_D1_NODE APPROX_2N7000
D1 CLIP_A M2_D1_NODE APPROX_1N34A
X3A CLIP_B X3_FB VCC_F 0 X3_OUT TL082
R11 X3_FB X3_RG 39k
R13 X3_FB X3_OUT 150k
C8 X3_RG VREF 100n
C9 X3_OUT X3_FB 220p
C10 X3_OUT TONE_TOP 10u
R_X4 TONE_TOP TONE_W 5k
C11 TONE_W 0 47n
R14 TONE_TOP VOL_TOP 22k
R15 TONE_TOP SW1_1 33k
SW1 SW1_1 VOL_TOP HP_CTRL 0 SW1MODEL
V_HP HP_CTRL 0 DC 5
R_VOL5A VOL_TOP OUT 50k
R_VOL5B OUT 0 50k
R_LOAD OUT 0 100k
R_LED VCC_F LED_A 4.7k
D_LED LED_A 0 LED_RED

* --- analyses ---
.op
.dc V1 8 18 1
.tran 10u 30m
.four 1k v(out)
.ac dec 200 20 20k
.noise v(OUT) V_AC dec 100 20 20k

.end
